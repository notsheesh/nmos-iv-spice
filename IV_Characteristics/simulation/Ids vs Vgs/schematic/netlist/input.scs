// Design: NMOS/IV_Characteristics
simulator lang=spectre
global 0
parameters VGS=0
include "/afs/ece.cmu.edu/class/ece622/cad_setup/gpdk045_v_2_0/models/spectre/gpdk045.scs" section=tt

// NMOS/IV_Characteristics/schematic
NM0 (net6 net3 0 0) gpdk045_nmos1v w=(120n) l=45n nf=1 m=(1)
Vgs (net3 0) vsource dc=VGS type=dc
Vds (net6 0) vsource dc=1.8 type=dc
simulatorOptions options temp=27
dc dc dev=Vds param=dc start=0 stop=1.8
save NM0:d
